*

.subckt Fake

.include "/Applications/KiCad/KiCad.app/Contents/SharedSupport/symbols/Simulation_SPICE.sp"
.model __D1 D
R20 Net-_U100-OUT_ Net-_U20--_ R_US
C20 unconnected-_C20-Pad1_ unconnected-_C20-Pad2_ C
R21 unconnected-_R21-Pad1_ unconnected-_R21-Pad2_ R_US
XU20 Net-_U20-+_ Net-_U20--_ unconnected-_U20-V+-Pad3_ unconnected-_U20-V--Pad4_ OUTPUT kicad_builtin_opamp
R22 OUTPUT Net-_U20-+_ R_US
R12 Net-_U100-IN_ Net-_U10-+_ R_US
R11 +5V Net-_U10-+_ R_US
R10 INPUT Net-_D1-K_ R_US
D1 0 Net-_D1-K_ __D1
XU10 Net-_U10-+_ Net-_D1-K_ unconnected-_U10-V+-Pad3_ unconnected-_U10-V--Pad4_ Net-_U100-IN_ kicad_builtin_opamp
C10 Net-_D1-K_ 0 C
U100 Net-_U100-OUT_ Net-_U100-IN_ IRL_BUFFER

.ends
